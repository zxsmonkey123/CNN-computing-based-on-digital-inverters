ADE simulation setup
Run mode: Single Run, Sweeps and Corners
Tests:
  lab3:CNN_inv:1: lab3/CNN_inv/schematic, simulator spectre
