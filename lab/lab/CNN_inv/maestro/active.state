ADE simulation setup
Test lab3:CNN_inv:1: lab3/CNN_inv/schematic, simulator spectre
  Models: /data/Project/tsmc_18rf/tsmc18rf/../models/spectre/rf018.scs[tt, tt_3v, tt_na, tt_3vna, tt_m, tt_3m, tt_bip, tt_bip3, dio, dio3, dio_dnw, tt_res, tt_mim, tt_rfmos, tt_rfmos33, tt_rfmim, tt_rfind, tt_rfmvar, tt_rfjvar, tt_rfres_sa, tt_rfres_rpo, tt_rfres_hri, tt_rfesd, tt_bbmvar]
  Temperature: 27
  Analysis tran: stop=40n errpreset=conservative
  Signals: /phi1, /phi2, /y11, /y12, /y21, /y22
Run mode: Single Run, Sweeps and Corners
