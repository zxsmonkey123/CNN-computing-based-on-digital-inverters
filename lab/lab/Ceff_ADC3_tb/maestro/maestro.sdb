ADE simulation setup
Run mode: Single Run, Sweeps and Corners
Tests:
  lab3:Ceff_ADC3_tb:1: lab3/Ceff_ADC3_tb/schematic, simulator spectre
    Variables: Vin = 4
