ADE simulation setup
Test lab3:Ceff_ADC3_tb:1: lab3/Ceff_ADC3_tb/schematic, simulator spectre
  Variables: Vin = 4
  Temperature: 27
  Analysis ac: start=100k stop=1M log=100
  Signals: /I4/Port_out (terminal)
Run mode: Single Run, Sweeps and Corners
