ADE simulation setup
Run mode: Single Run, Sweeps and Corners
Tests:
  lab3:inv_adder:1: lab3/inv_adder/schematic, simulator spectre
    Variables: C1 = 10f; C2 = 10f; C3 = 92.4f; vin1a = 100m; vin1b = 2; vin2a = 120m; vin2b = 3
