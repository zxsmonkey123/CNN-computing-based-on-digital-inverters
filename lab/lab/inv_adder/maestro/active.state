ADE simulation setup
Test lab3:inv_adder:1: lab3/inv_adder/schematic, simulator spectre
  Models: /data/Project/tsmc_18rf/models/spectre/rf018.scs[tt]
  Variables: C1 = 10f; C2 = 10f; C3 = 92.4f; vin1a = 100m; vin1b = 2; vin2a = 120m; vin2b = 3
  Temperature: 27
  Analysis tran: stop=30n errpreset=conservative
  Signals: /vout, /phi1, /phi2, /vin1a, /vin2a, /net05
Run mode: Single Run, Sweeps and Corners
