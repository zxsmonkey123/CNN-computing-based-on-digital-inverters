ADE simulation setup
Run mode: Single Run, Sweeps and Corners
Tests:
  lab3:CNN_inv_tb:1: lab3/CNN_inv_tb/schematic, simulator spectre
    Variables: kernel1 = 2; kernel2 = 3; x11 = 1; x12 = 2; x13 = 3; x21 = 4; x22 = 5; x23 = 6
