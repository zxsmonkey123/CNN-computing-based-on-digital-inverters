ADE simulation setup
Test lab3:CNN_inv_tb:1: lab3/CNN_inv_tb/schematic, simulator spectre
  Models: /data/Project/tsmc_18rf/tsmc18rf/../models/spectre/rf018.scs[tt, tt_3v, tt_na, tt_3vna, tt_m, tt_3m, tt_bip, tt_bip3, dio, dio3, dio_dnw, tt_res, tt_mim, tt_rfmos, tt_rfmos33, tt_rfmim, tt_rfind, tt_rfmvar, tt_rfjvar, tt_rfres_sa, tt_rfres_rpo, tt_rfres_hri, tt_rfesd, tt_bbmvar]
  Variables: kernel1 = 2; kernel2 = 3; x11 = 1; x12 = 2; x13 = 3; x21 = 4; x22 = 5; x23 = 6
  Temperature: 27
  Analysis tran: stop=40n errpreset=conservative
  Signals: /y11, /y12, /y21, /y22, /phi1
Run mode: Single Run, Sweeps and Corners
