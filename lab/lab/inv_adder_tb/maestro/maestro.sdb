ADE simulation setup
Run mode: Single Run, Sweeps and Corners
Tests:
  lab3:inv_adder_tb:1: lab3/inv_adder_tb/schematic, simulator spectre
    Variables: vin1a = 20m; vin1b = 2; vin2a = 40m; vin2b = 3
