ADE simulation setup
Test lab3:inv_adder_tb:1: lab3/inv_adder_tb/schematic, simulator spectre
  Models: /data/Project/tsmc_18rf/tsmc18rf/../models/spectre/rf018.scs[tt, tt_3v, tt_na, tt_3vna, tt_m, tt_3m, tt_bip, tt_bip3, dio, dio3, dio_dnw, tt_res, tt_mim, tt_rfmos, tt_rfmos33, tt_rfmim, tt_rfind, tt_rfmvar, tt_rfjvar, tt_rfres_sa, tt_rfres_rpo, tt_rfres_hri, tt_rfesd, tt_bbmvar]
  Variables: vin1a = 20m; vin1b = 2; vin2a = 40m; vin2b = 3
  Temperature: 27
  Analysis tran: stop=40n errpreset=conservative
  Signals: /phi1, /phi2, /vout
Run mode: Single Run, Sweeps and Corners
